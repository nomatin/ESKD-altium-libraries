* MY_LIB original P-channel MOSFET electrical approximation from datasheets only.
* Mirror of MY_LIB_NMOS_DS.ckt: same eight VT_* parameters, same node order.
* No manufacturer SPICE model was used. External pin order: 1=GATE, 2=SOURCE, 3=DRAIN.
* Component-specific values are passed from Excel/DbLib as parameters.
* All voltages/currents are negative in normal P-channel operation, as in the
*   datasheets, so VT_VTO of a P-channel part is entered with a negative sign.
*
* Fitting policy, model topology and all limitations are identical to the
*   N-channel file; see MY_LIB_NMOS_DS.ckt and README.md for the argument:
*   datasheet LIMITS (not a typical device), MOS3 (LEVEL=3) so that the ratio
*   of the two published RDS(on) limits is reproduced by THETA instead of an
*   artificial series resistor; RD/RS stay zero; GAMMA=0 and PHI=0.7 because
*   the datasheets carry no substrate-bias data.
* W=L=1 um is a numerical identity (W/L=1 keeps KP), NOT device geometry.
* Capacitances are explicit linear elements:
*   CGS = Ciss-Crss, CGD = Crss, CDS = Coss-Crss at the datasheet VDS, 1 MHz.
* Body diode: for a P-channel device the anode is the DRAIN and the cathode is
*   the SOURCE, i.e. the reverse of the N-channel part; the terminal order of
*   Dbody is therefore (3,2), not (2,3).
* Body diode is fitted to the typical VSD point; no reverse recovery, no
*   CJO/TT, no breakdown, no self-heating, no temperature dependence, no gate
*   charge, no Qrr, no tolerances.
.SUBCKT MY_LIB_PMOS_DS 1 2 3 PARAMS: VTO=-2 KP=0.2 THETA=0 RD=0 RS=0
+ CGS=0 CGD=0 CDS=0 ISbody=1e-14 Nbody=1
Mchannel 3 1 2 2 MY_LIB_PMOS_CORE L=1e-6 W=1e-6
* IS=1e-30 disables the intrinsic drain-body junction of the LEVEL=3 device so
* that the ISbody parameter alone defines the body diode (same defect and same
* fix as in MY_LIB_NMOS_DS.ckt: the intrinsic junction with the SPICE default
* IS=1e-14 otherwise dominates the explicit Dbody element).
.MODEL MY_LIB_PMOS_CORE PMOS (IS=1e-30 LEVEL=3 VTO={VTO} KP={KP} THETA={THETA}
+ GAMMA=0 PHI=0.7 RD={RD} RS={RS} CGSO=0 CGDO=0 CGBO=0)
Cgs 1 2 {CGS}
Cgd 1 3 {CGD}
Cds 3 2 {CDS}
Dbody 3 2 DBODY
.MODEL DBODY D (IS={ISbody} N={Nbody} RS=0 CJO=0 TT=0)
.ENDS MY_LIB_PMOS_DS
