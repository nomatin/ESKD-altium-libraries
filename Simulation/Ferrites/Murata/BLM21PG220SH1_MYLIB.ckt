* Independent passive RLC fit to sampled output of a Murata model (ngspice).
* Derived from Murata model behavior; 25 degC, 0 A DC bias, small signal.
* Fit range 1 MHz to 3 GHz; DC set from supplied near-DC output.
.SUBCKT BLM21PG220SH1_MYLIB 1 2
Cpar 1 2 1.04638681783063e-16
Rdc 1 n0 0.00300000000006367
Linf n0 n1 7.50143897260915e-10
R1 n1 n2 468.619487036548
L1 n1 n2 4.13131949839898e-10
Rc1 n1 c1 0.0205607633977161
C1 c1 n2 2.43829714213002e-06
R2 n2 n3 53461.9629735751
L2 n2 n3 1.99693327718256e-10
Rc2 n2 c2 0.0218024470501139
C2 c2 n3 6.75324696023648e-07
R3 n3 n4 21980.9719103914
L3 n3 n4 3.21240948707238e-10
Rc3 n3 c3 0.0210195012935122
C3 c3 n4 1.0860468966086e-06
R4 n4 n5 9.03850138709239
L4 n4 n5 1.16434321978167e-07
Rc4 n4 c4 0.00100413665779727
C4 c4 n5 2.68928033035753e-12
R5 n5 n6 0.0138173752879101
L5 n5 n6 4.57117156690464e-10
Rc5 n5 c5 5571.28232590401
C5 c5 n6 1.61271331682646e-15
R6 n6 n7 0.0121410036420319
L6 n6 n7 4.00973923656949e-10
Rc6 n6 c6 2982.40630646145
C6 c6 n7 1.74346469642152e-15
R7 n7 n8 20.2068263722118
L7 n7 n8 3.87205683479126e-08
Rc7 n7 c7 0.00112460203316541
C7 c7 n8 1.1906101614244e-12
R8 n8 n9 0.00952223913316535
L8 n8 n9 3.11069626830096e-10
Rc8 n8 c8 309471.228861952
C8 c8 n9 5.55541861107103e-13
R9 n9 n10 0.0499460879101457
L9 n9 n10 1.27071591246719e-10
Rc9 n9 c9 0.00180677696920605
C9 c9 n10 4.66640541564359e-10
R10 n10 2 0.00598568235998498
L10 n10 2 5.8378919829713e-11
Rc10 n10 c10 87105.4253720113
C10 c10 2 1.69413544430355e-14
.ENDS BLM21PG220SH1_MYLIB
