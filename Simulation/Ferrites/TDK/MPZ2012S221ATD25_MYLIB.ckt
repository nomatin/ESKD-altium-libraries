* Independently authored passive behavioral approximation.
* Fitted only to official TDK model output, not its circuit or parameters.
* Source: native Altium MixedSim, 25 C, zero DC bias, linear small signal.
* Validated sample interval: 1 MHz to 3 GHz; no temperature/current dependence.
* DCR fixed to supplied DC reference; datasheet 2019-04-23 maximum respected.
.SUBCKT MPZ2012S221ATD25_MYLIB 1 2
Rdc 1 n0 0.0279999999912
Lmain n0 2 1.07854464624e-06
R1 1 a0 534.903784892
L1 a0 b0 9.07834397363e-06
C1 b0 2 2.47140395543e-11
R2 1 a1 804.051196253
L2 a1 b1 2.66508844319e-05
C2 b1 2 1.66476981731e-11
R3 1 a2 563.698753509
L3 a2 b2 3.90231441148e-06
C3 b2 2 2.48270256256e-11
R4 1 a3 1826.14160738
L4 a3 b3 7.71421187635e-06
C4 b3 2 3.37970652147e-09
R5 1 a4 260.066032121
L5 a4 b4 4.84764958572e-07
C5 b4 2 4.4865811025e-11
R6 1 a5 240.847739125
L6 a5 b5 3.4982809048e-09
C6 b5 2 9.73059382065e-12
R7 1 a6 402.477152189
L7 a6 b6 5.88335764736e-09
C7 b6 2 9.84679343037e-14
R8 1 a7 18.0019897777
L8 a7 b7 2.21840946047e-11
C8 b7 2 7.13799002242e-13
.ENDS MPZ2012S221ATD25_MYLIB
