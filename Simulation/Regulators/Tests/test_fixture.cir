TLV75533PDBVR independent verification at 25 C
.temp 25
V1 in1 0 5
C1 in1 0 1u
Ve en 0 PULSE(0 5 1m 5u 5u 2m 10m)
Xstartup in1 0 en startup MY_LIB_TLV75533P_DS
Cstartup startup 0 1u
Rstartup startup 0 33
V2 in2 0 4.3
C2 in2 0 1u
Xload in2 0 in2 loaded MY_LIB_TLV75533P_DS
Cloaded loaded 0 1u
Iload loaded 0 PWL(0 1m 2m 1m 2.01m 500m)
V3 in3 0 PWL(0 4.3 1.5m 4.3 1.6m 3.3 3m 3.3 3.1m 4.3)
C3 in3 0 1u
Xdrop in3 0 in3 drop MY_LIB_TLV75533P_DS
Cdrop drop 0 1u
Idrop drop 0 PWL(0 1m 1m 1m 1.1m 500m)
V4 in4 0 3.8
C4 in4 0 1u
Xlimit in4 0 in4 ocout MY_LIB_TLV75533P_DS
Climit ocout 0 1u
Vlimit ocout 0 2.97
V5 in5 0 3.8
C5 in5 0 1u
Xshort in5 0 in5 short MY_LIB_TLV75533P_DS
Cshort short 0 1u
Vshort short 0 0
V6 in6 0 1.2
C6 in6 0 1u
Xuvlo in6 0 in6 uvlo MY_LIB_TLV75533P_DS
Ruvlo uvlo 0 3300
Cuvlo uvlo 0 1u
V7 in7 0 5.5
C7 in7 0 1u
Xdischarge in7 0 en disch MY_LIB_TLV75533P_DS
Cdischarge disch 0 1u
Rdischarge disch 0 1meg
V8 in8 0 3.8
Xopen in8 0 in8 unloaded MY_LIB_TLV75533P_DS
Copen unloaded 0 1u
.include "../MY_LIB_TLV75533P_DS.ckt"
.tran 0.5u 4m 0 0.5u
.meas tran unloaded FIND v(unloaded) AT=3.5m
.meas tran off_before FIND v(startup) AT=0.9m
.meas tran startup_90 TRIG v(en) VAL=1 RISE=1 TARG v(startup) VAL=2.97 RISE=1
.meas tran on_100ma FIND v(startup) AT=2.5m
.meas tran off_after FIND v(startup) AT=3.9m
.meas tran out_1ma FIND v(loaded) AT=1.8m
.meas tran out_500ma FIND v(loaded) AT=3.5m
.meas tran dropout_out FIND v(drop) AT=2.8m
.meas tran dropout_recovery FIND v(drop) AT=3.9m
.meas tran current_limit FIND i(Vlimit) AT=3.5m
.meas tran short_limit FIND i(Vshort) AT=3.5m
.meas tran below_uvlo FIND v(uvlo) AT=3.5m
.meas tran discharge_1e TRIG v(en) VAL=0.3 FALL=1 TARG v(disch) VAL=1.214 FALL=1
.end
