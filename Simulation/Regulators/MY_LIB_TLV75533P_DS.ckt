* TLV75533PDBVR independent behavioral model, typical 25 deg C.
* Source: TI SBVS320D sections 5.5, 6.3, 6.4 and 7.2.
* Ports in physical pin order: 1=IN 2=GND 3=EN 5=OUT. Pin 4 is NC.
* Use external CIN and COUT as specified in the datasheet.
* No hysteresis, thermal behavior, process corners, PSRR, noise,
* loop stability, reverse current or calibrated line/load dynamics.
.SUBCKT MY_LIB_TLV75533P_DS IN GND EN OUT
* Model assumptions: EN threshold 0.65 V, 20 mV numerical transition;
* UVLO 1.30 V rising and falling, 20 mV numerical transition.
EEnable Enabled GND VALUE={MIN(MAX((V(EN,GND)-0.64)/0.02,0),1)
+ *MIN(MAX((V(IN,GND)-1.29)/0.02,0),1)}
* Approximate startup with a first-order ramp: tau=239 us, t90=550 us.
* Reset the startup state quickly when disabled (tau=1 us).
GSoft GND Soft VALUE={(V(Enabled,GND)-V(Soft,GND))
+ *(V(Enabled,GND)/239+(1-V(Enabled,GND))/1)}
CSoft Soft GND 1u
* Pass current limited by regulation, dropout headroom and foldback.
* 0.060 ohm regulates output load slope; 0.30 ohm produces 150 mV
* headroom at 500 mA. Independent piecewise-linear foldback joins
* 355 mA at a short and 720 mA at 90% of nominal output.
GPass IN OUT VALUE={V(Enabled,GND)*MAX(0,
+ MIN(MIN((3.3*V(Soft,GND)-V(OUT,GND))/0.060,
+ V(IN,OUT)/0.30),0.355+0.365*MIN(MAX(V(OUT,GND)/2.97,0),1)))}
* Active output discharge; fully unpowered behavior is outside scope.
GDischarge OUT GND VALUE={(1-V(Enabled,GND))*V(OUT,GND)/120}
* Typical no-load ground currents. Low-voltage ramp avoids a fixed
* current sink on an unpowered VIN node.
GIq IN GND VALUE={MIN(MAX(V(IN,GND)/1.3,0),1)
+ *(0.1u+(25u-0.1u)*V(Enabled,GND))}
* Numerical DC path for an unloaded output; not a measured leakage.
RNoLoad OUT GND 1G
* EN leakage represented by the specified 10 nA at 5.5 V.
REn EN GND 550MEG
.ENDS MY_LIB_TLV75533P_DS
