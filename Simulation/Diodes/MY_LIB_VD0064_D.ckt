* BZT52-B5V6 | Nexperia
* Source: Datasheets/Diodes/BZT52_B_Nexperia.pdf
* Revision: Rev. 2, 06-Feb-2024; B selection
* Datasheet-limit approximation at 25C. IS/N/RS fitted or assumed, not manufacturer model parameters. Single VF point: N assumed 2, RS=0. CJO converted from Cd using assumed VJ=1,M=0.5. TT omitted; trr is not TT. No validated switching, thermal or tolerance model. Nominal Zener BV/IBV; knee, dynamic resistance and temperature drift not fitted.
* VF anchors (A,V): [[0.01, 0.9]]
.SUBCKT MY_LIB_VD0064_D A K
Dcore A K CORE
.MODEL CORE D (IS=2.47414713594e-10 N=2 RS=0 TNOM=25 CJO=3e-10 VJ=1 M=0.5 BV=5.6 IBV=0.005)
.ENDS MY_LIB_VD0064_D
