* SS33A | Yangjie
* Source: Datasheets/Diodes/SS32A_SS320A_Yangjie.pdf
* Revision: Rev. 2.4, 28-Apr-2014
* Datasheet-limit approximation at 25C. IS/N/RS fitted or assumed, not manufacturer model parameters. Single VF point: N assumed 1, RS=0. Capacitance unavailable in tabular data: omitted. TT omitted; trr is not TT. No validated switching, thermal or tolerance model. BV omitted: rated reverse voltage is not measured breakdown voltage.
* VF anchors (A,V): [[3.0, 0.5]]
.SUBCKT MY_LIB_VD0047_D A K
Dcore A K CORE
.MODEL CORE D (IS=1.06016100459e-08 N=1 RS=0 TNOM=25)
.ENDS MY_LIB_VD0047_D
