* TT=2.71337373193e-08s fitted to MAX trr=4e-09s at 25C, IF=0.01A, measured IRpeak=0.0692277284553A, RL=100ohm, recovery threshold=0.001A.
* Drive final=-6V, ideal 10ps edge; RL=100ohm for ES1 is fixture assumption. Qrr/full waveform/temperature dependence unvalidated.
* VF fit shifted down to respect every tabulated maximum at 25C (10uV numerical margin).
* 1N4148W | Vishay
* Source: Datasheets/Diodes/1N4148W_Vishay.pdf
* Revision: Rev. 1.0, 16-Nov-2023
* Datasheet-limit approximation at 25C. IS/N/RS fitted or assumed, not manufacturer model parameters. Least-squares fit to VF maximum test points. CJO converted from Cd using assumed VJ=1,M=0.5. TT fitted to datasheet trr test fixture as detailed above. No validated switching, thermal or tolerance model. BV omitted: rated reverse voltage is not measured breakdown voltage.
* VF anchors (A,V): [[0.01, 1.0], [0.1, 1.2]]
.SUBCKT MY_LIB_VD0001_D A K
Dcore A K CORE
.MODEL CORE D (IS=1.5392074753287e-11 N=1.89938725075 RS=0.973707839663 TNOM=25 CJO=1.5e-12 VJ=1 M=0.5 TT=2.7133737319309e-08)
.ENDS MY_LIB_VD0001_D
