* SS110A | Yangjie
* Source: Datasheets/Diodes/SS12A_SS120A_Yangjie.pdf
* Revision: Rev. 2.8, 19-Sep-2022
* Datasheet-limit approximation at 25C. IS/N/RS fitted or assumed, not manufacturer model parameters. Single VF point: N assumed 1, RS=0. Capacitance unavailable in tabular data: omitted. TT omitted; trr is not TT. No validated switching, thermal or tolerance model. BV omitted: rated reverse voltage is not measured breakdown voltage.
* VF anchors (A,V): [[1.0, 0.85]]
.SUBCKT MY_LIB_VD0034_D A K
Dcore A K CORE
.MODEL CORE D (IS=4.28574145703e-15 N=1 RS=0 TNOM=25)
.ENDS MY_LIB_VD0034_D
