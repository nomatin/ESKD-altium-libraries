* VF fit shifted down to respect every tabulated maximum at 25C (10uV numerical margin).
* EG=0.69eV, XTI=2 are standard Schottky class assumptions (ngspice manual), not measured/fitted manufacturer parameters. Temperature accuracy remains unvalidated; no VF(T) data in the tabulated source.
* SS38A | Yangjie
* Source: Datasheets/Diodes/SS32A_SS320A_Yangjie.pdf
* Revision: Rev. 2.4, 28-Apr-2014
* Datasheet-limit approximation at 25C. IS/N/RS fitted or assumed, not manufacturer model parameters. Single VF point: N assumed 1, RS=0. Capacitance unavailable in tabular data: omitted. TT omitted; trr is not TT. No validated switching, thermal or tolerance model. BV omitted: rated reverse voltage is not measured breakdown voltage.
* VF anchors (A,V): [[3.0, 0.85]]
.SUBCKT MY_LIB_VD0051_D A K
Dcore A K CORE
.MODEL CORE D (IS=1.2862229601107e-14 N=1 RS=0 TNOM=25 EG=0.69 XTI=2)
.ENDS MY_LIB_VD0051_D
