* Native AD24.4 NSX probe: TBV1 had no effect; TCV applies breakdown temperature shift.
* NBV constrained by both datasheet rdif maxima and IR<=5e-08A at VR=47.6V; 5% guard. Local rdif<=160ohm at 0.002A, not an exact measured knee.
* SZ scenario: midpoint of datasheet range [65.6,79.8]mV/K at 0.002A. Not typical/measured; no tolerance sweep. TCV (MixedSim, V/K, BV(T)=BV-TCV*(T-25)) locally calibrated at 25C; linear extrapolation not a measured full-temperature curve.
* BZT52-C68 | Nexperia
* Source: Datasheets/Diodes/BZT52_C_Nexperia.pdf
* Revision: Rev. 1, 16-Mar-2017; C selection
* Datasheet-limit approximation at 25C. IS/N/RS fitted or assumed, not manufacturer model parameters. Single VF point: N assumed 2, RS=0. CJO converted from Cd using assumed VJ=1,M=0.5. TT omitted; trr is not TT. No validated switching, thermal or tolerance model. Nominal VZ and local rdif/SZ scenarios calibrated as detailed above; full knee/leakage not fitted.
* VF anchors (A,V): [[0.01, 0.9]]
.SUBCKT MY_LIB_VD0127_D A K
Dcore A K CORE
.MODEL CORE D (IS=2.47414713594e-10 N=2 RS=0 TNOM=25 CJO=3.5e-11 VJ=1 M=0.5 BV=67.999940576775 IBV=0.002 NBV=7.3951314544077 TCV=-0.0726951511419529)
.ENDS MY_LIB_VD0127_D
