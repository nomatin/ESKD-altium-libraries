* BAT54S Nexperia; standard SPICE D approximation.
* Source: Datasheets/Diodes/BAT54_series_Nexperia.pdf
* Per-junction VF maximum anchors and capacitance from this datasheet.
* IS/N/RS fitted to VF maxima; CJO shape VJ=1 M=.5 assumed.
* No validated switching, leakage, temperature drift, breakdown or thermal coupling.
* TT omitted: trr is not TT. Rated reverse voltage is not BV.
.SUBCKT MY_LIB_VD0027_DUAL 1 2 3
D1 1 3 CORE
D2 3 2 CORE
.MODEL CORE D (IS=7.20785039475e-09 N=1.00253520931 RS=3.74820731501 TNOM=25 CJO=1.41421356237e-11 VJ=1 M=0.5)
.ENDS MY_LIB_VD0027_DUAL
