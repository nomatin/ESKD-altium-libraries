* VF fit shifted down to respect every tabulated maximum at 25C (10uV numerical margin).
* S1A | Diotec Semiconductor
* Source: Datasheets/Diodes/S1A_S1Y_Diotec.pdf
* Revision: 2026-04-02
* Datasheet-limit approximation at 25C. IS/N/RS fitted or assumed, not manufacturer model parameters. Single VF point: N assumed 2, RS=0. Capacitance unavailable in tabular data: omitted. TT omitted; trr is not TT. No validated switching, thermal or tolerance model. BV omitted: rated reverse voltage is not measured breakdown voltage.
* VF anchors (A,V): [[1.0, 1.1]]
.SUBCKT MY_LIB_VD0006_D A K
Dcore A K CORE
.MODEL CORE D (IS=5.0484742346419e-10 N=2 RS=0 TNOM=25)
.ENDS MY_LIB_VD0006_D
