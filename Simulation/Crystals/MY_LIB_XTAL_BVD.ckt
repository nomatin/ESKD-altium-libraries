* MY_LIB quartz resonator, fundamental-mode small-signal BVD model
* Ports: 1 crystal, 2 case, 3 crystal, 4 case. Case coupling omitted.
* FnomMHz is the loaded frequency with external CLpF across pins 1 and 3.
* Defaults describe the documented XL2OI-111-8M calculation scenario.
.SUBCKT MY_LIB_XTAL_BVD 1 2 3 4 PARAMS: FnomMHz=8 CLpF=12 RmOhm=150 C0pF=2 CmfF=5
.PARAM W0={6.283185307179586*FnomMHz*1e6}
.PARAM BC={W0*(C0pF+CLpF)*1e-12}
.PARAM XLOAD={(1+SQRT(1-4*BC*BC*RmOhm*RmOhm))/(2*BC)}
.PARAM LM={(XLOAD+1/(W0*CmfF*1e-15))/W0}
RM 1 MR {RmOhm}
LMOT MR ML {LM}
CMOT ML 3 {CmfF*1e-15}
CSH 1 3 {C0pF*1e-12}
.ENDS MY_LIB_XTAL_BVD
