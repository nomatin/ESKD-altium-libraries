* MY_LIB YAGEO CC: nominal capacitance, DFmax-derived Rs, minimum insulation.
* X7R: YAGEO V.27, DF at 1 kHz. C0G: YAGEO NP0 V.22, DF at 1 MHz (C <= 1 nF) or 1 kHz.
* Rs=DFmax/(2*pi*f_test*Cnom); Rins=min(1e10,K/Cnom). See catalog for f_test and K.
* Constant Rs represents the test frequency. Leakage adds a small extra AC loss.
* No tolerance, temperature, DC bias, ESL, aging, absorption or breakdown.
.SUBCKT MY_LIB_C_RC 1 2 PARAMS: Cvalue=1n Rsvalue=1 Rinsvalue=1e10
Rloss 1 3 {Rsvalue}
Cmain 3 2 {Cvalue}
Rleak 1 2 {Rinsvalue}
.ENDS MY_LIB_C_RC
